TI buffer DC model test
.include "/mnt/c/Users/abbii/Documents/Codex/2026-10-26/files-pasted-by-the-user-setup/outputs/microduck-assets/electrical-models/ti-sn74lvc2g241/SN74LVC2G241.cir"
Vcc vcc 0 3.3
Vin input 0 0
Voe enable 0 3.3
Vpull pull 0 3.3
Xbuffer output input enable vcc 0 SN74LVC2G241
Rload output pull 10k
.op
.control
run
print v(output)
quit
.endc
.end
